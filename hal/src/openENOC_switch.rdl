// SPDX-FileCopyrightText: 2026 Enio Kaljic
// SPDX-License-Identifier: CERN-OHL-S-2.0

addrmap openENOC_switch #(
    longint unsigned NUM_OF_INTERFACES = 8,
    longint unsigned TABLE_DEPTH = 32,
    string INST_NAME = "openENOC_switch"
) {
    name = INST_NAME;
    desc = "Control and status register map for an openENOC Switch instance. It includes configuration registers and a forwarding table used to map destination MAC address keys to output interface selections for frame forwarding.";

    default accesswidth = 32;
    default regwidth = 32;
    default alignment = 4;
    addressing = regalign;

    reg info {
        name = {INST_NAME, ".info"};
        desc = "Read-only information register for this openENOC Switch instance.";

        field {
            name = {INST_NAME, ".info.num_of_interfaces[21:16]"};
            desc = "Number of interfaces in this openENOC Switch instance. This field reflects the NUM_OF_INTERFACES parameter value.";

            sw = r;
            hw = r;
        } num_of_interfaces[21:16] = NUM_OF_INTERFACES;

        field {
            name = {INST_NAME, ".info.table_depth[15:0]"};
            desc = "Depth of the forwarding table in this openENOC Switch instance. This field reflects the TABLE_DEPTH parameter value.";

            sw = r;
            hw = r;
        } table_depth[15:0] = TABLE_DEPTH;
    } info;

    reg forwarding_control {
        name = {INST_NAME, ".forwarding_control"};
        desc = "Forwarding control register for the openENOC Switch instance.";

        field {
            name = {INST_NAME, ".forwarding_control.operation_mode[0:0]"};
            desc = "Mode of operation for the openENOC Switch instance. When set to 1, the switch operates in managed mode, allowing software to configure the forwarding table and control forwarding operations. When set to 0, the switch operates in unmanaged mode, where forwarding state is maintained autonomously by internal hardware logic without software intervention.";

            sw = rw;
            hw = r;
        } operation_mode[0:0] = 0;

        field {
            name = {INST_NAME, ".forwarding_control.pause_request[7:7]"};
            desc = "Pause request for the forwarding logic. When set, this field requests the switch to pause frame forwarding and clear its internal pipeline before forwarding table updates are performed.";


            sw = rw;
            hw = r;
        } pause_request[7:7] = 0;

        field {
            name = {INST_NAME, ".forwarding_control.pause_done[15:15]"};
            desc = "Pause done status. When set, this field indicates that the switch has paused frame forwarding and reached a safe state for forwarding table modification.";

            sw = r;
            hw = w;
        } pause_done[15:15];
    } forwarding_control;

    reg default_forwarding {
        name = {INST_NAME, ".default_forwarding"};
        desc = "Defines the destination interface or interfaces for frames that do not match any enabled forwarding table entry.";

        field {
            name = {INST_NAME, ".default_forwarding.bitmap[NUM_OF_INTERFACES-1:0]"};
            desc = "Bitmap selecting the output interface or interfaces to which frames that do not match any enabled forwarding table entry are forwarded. Bit NUM_OF_INTERFACES-1, the MSB, corresponds to the first interface; bit 0 corresponds to the last interface.";

            sw = rw;
            hw = r;
        } bitmap[NUM_OF_INTERFACES-1:0] = 0;
    } default_forwarding;

    external regfile forwarding_table {
        name = {INST_NAME, ".forwarding_table"};
        desc = "Forwarding table used to map MAC addresses to output interface selections for frame forwarding.";

        regfile entry {
            name = {INST_NAME, ".forwarding_table.entry[0..TABLE_DEPTH-1]"};
            desc = "Forwarding table entry containing the MAC address key, output interface selection, and entry configuration.";

            reg macaddr {
                name = {INST_NAME, ".forwarding_table.entry[0..TABLE_DEPTH-1].macaddr"};
                desc = "48-bit destination MAC address used as the key for this forwarding table entry.";

                regwidth = 64;

                field {
                    name = {INST_NAME, ".forwarding_table.entry[0..TABLE_DEPTH-1].macaddr.hi_word[47:32]"};
                    desc = "Upper 16 bits [47:32] of the 48-bit MAC address stored in this forwarding table entry.";

                    sw = rw;
                    hw = rw;
                } hi_word[47:32];

                field {
                    name = {INST_NAME, ".forwarding_table.entry[0..TABLE_DEPTH-1].macaddr.lo_word[31:0]"};
                    desc = "Lower 32 bits [31:0] of the 48-bit MAC address stored in this forwarding table entry.";

                    sw = rw;
                    hw = rw;
                } lo_word[31:0];
            } macaddr;

            reg iface {
                name = {INST_NAME, ".forwarding_table.entry[0..TABLE_DEPTH-1].iface"};
                desc = "Forwarding interface information associated with this forwarding table entry.";

                field {
                    name = {INST_NAME, ".forwarding_table.entry[0..TABLE_DEPTH-1].iface.bitmap[NUM_OF_INTERFACES-1:0]"};
                    desc = "Bitmap selecting the output interface or interfaces to which a matching frame is forwarded. Bit NUM_OF_INTERFACES-1, the MSB, corresponds to the first interface; bit 0 corresponds to the last interface.";

                    sw = rw;
                    hw = rw;
                } bitmap[NUM_OF_INTERFACES-1:0];
            } iface;

            reg config {
                name = {INST_NAME, ".forwarding_table.entry[0..TABLE_DEPTH-1].config"};
                desc = "Configuration information associated with this forwarding table entry.";

                field {
                    name = {INST_NAME, ".forwarding_table.entry[0..TABLE_DEPTH-1].config.enabled"};
                    desc = "Enables this forwarding table entry. When cleared, the entry is ignored during forwarding table lookup.";

                    sw = rw;
                    hw = rw;
                } enabled;
            } config;
        } entry[TABLE_DEPTH];
    } forwarding_table;
};
