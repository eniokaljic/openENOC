// SPDX-FileCopyrightText: 2026 Enio Kaljic
// SPDX-License-Identifier: CERN-OHL-S-2.0

regfile openenoc_endpoint_interface #(
    longint unsigned RMEM_TOTAL_DEPTH = 256,
    longint unsigned NUM_OF_PEERS = 1,
    longint unsigned MAX_RAW_FRAME_SIZE = 8192,
    longint unsigned HAS_PEER_DMA = 1,
    longint unsigned HAS_NON_OETP_DMA = 1,
    longint unsigned HAS_DIRECT_AXIS = 1,
    longint unsigned HAS_RMEM = 1,
    longint unsigned HAS_IRQ = 1,
    string INST_NAME = "openenoc_endpoint_interface"
) {
    name = INST_NAME;
    desc = "Control and status register file for an openENOC Endpoint Interface instance.";

    default accesswidth = 32;
    default regwidth = 32;
    default alignment = 4;

    reg info {
        name = {INST_NAME, ".info"};
        desc = "Read-only information register for this openENOC Endpoint Interface instance.";

        regwidth = 64;

        field {
            name = {INST_NAME, ".info.rmem_total_depth[31:0]"};
            desc = "Total depth of the shared memory region for all remote peers. This field
                reflects the RMEM_TOTAL_DEPTH parameter value.";

            sw = r;
            hw = r;
        } rmem_total_depth[31:0] = RMEM_TOTAL_DEPTH;

        field {
            name = {INST_NAME, ".info.num_of_peers[42:32]"};
            desc = "Number of remote peers supported by this openENOC Endpoint Interface instance,
                from 0 to 2047. This field reflects the NUM_OF_PEERS parameter value.";

            sw = r;
            hw = r;
        } num_of_peers[42:32] = NUM_OF_PEERS;

        field {
            name = {INST_NAME, ".info.peer_dma_supported"};
            desc = "Indicates whether DMA transfers associated with configured remote peers are
                supported.";

            sw = r;
            hw = r;
        } peer_dma_supported[43:43] = HAS_PEER_DMA;

        field {
            name = {INST_NAME, ".info.non_oetp_dma_supported"};
            desc = "Indicates whether endpoint-level DMA transfers of complete non-oETP Ethernet
                frames are supported.";

            sw = r;
            hw = r;
        } non_oetp_dma_supported[44:44] = HAS_NON_OETP_DMA;

        field {
            name = {INST_NAME, ".info.direct_axis_supported"};
            desc = "Indicates whether direct CSR-driven AXI4-Stream access is supported for
                non-oETP Ethernet frames.";

            sw = r;
            hw = r;
        } direct_axis_supported[45:45] = HAS_DIRECT_AXIS;

        field {
            name = {INST_NAME, ".info.rmem_supported"};
            desc = "Indicates whether the transparent Remote Memory (RMEM) interface is supported.";

            sw = r;
            hw = r;
        } rmem_supported[46:46] = HAS_RMEM;

        field {
            name = {INST_NAME, ".info.irq_supported"};
            desc = "Indicates whether the endpoint interrupt output and interrupt-control logic
                are implemented.";

            sw = r;
            hw = r;
        } irq_supported[47:47] = HAS_IRQ;

        field {
            name = {INST_NAME, ".info.max_dma_frame_size_bytes[63:48]"};
            desc = "Synthesis-time maximum Ethernet frame size in bytes, excluding FCS. This
                field reflects the MAX_RAW_FRAME_SIZE parameter value and bounds raw
                non-oETP DMA frames. The peer DMA memory-fragment ceiling is
                4 * floor((MAX_RAW_FRAME_SIZE - 32) / 4), accounting for the Ethernet
                header, oETP write metadata, data-word padding and EndOfData. An 8192-byte
                frame limit permits 8160-byte memory fragments. A value of zero indicates
                that DMA is not supported.";

            sw = r;
            hw = r;
        } max_dma_frame_size_bytes[63:48] = MAX_RAW_FRAME_SIZE;
    } info;

    regfile config {
        name = {INST_NAME, ".config"};
        desc = "Configuration register file for this openENOC Endpoint Interface instance.";

        reg mac_address {
            name = {INST_NAME, ".config.mac_address"};
            desc = "Local endpoint 48-bit unicast MAC address. The oETP engine uses this address
                as its source MAC and compares individual-addressed incoming oETP frames against
                it. The I/G bit in the first MAC octet must be zero. Group-addressed oETP frames
                are compared against config.multicast_address instead.";

            regwidth = 64;

            field {
                name = {INST_NAME, ".config.mac_address.lo_word[31:0]"};
                desc = "Lower 32 bits [31:0] of the 48-bit MAC address.";

                sw = rw;
                hw = r;
            } lo_word[31:0] = 0;

            field {
                name = {INST_NAME, ".config.mac_address.hi_word[47:32]"};
                desc = "Upper 16 bits [47:32] of the 48-bit MAC address.";

                sw = rw;
                hw = r;
            } hi_word[47:32] = 0;
        } mac_address;

        reg multicast_address {
            name = {INST_NAME, ".config.multicast_address"};
            desc = "Local endpoint 48-bit multicast destination MAC address. For an incoming
                oETP frame whose destination I/G bit is one, the engine accepts the destination
                only when it exactly matches this address. All slave endpoints in a replication
                group use the same value. This address is not used as a source MAC. Zero is the
                reset value and matches no group-addressed destination, disabling oETP group
                reception. Broadcast is accepted only when this address is all ones. This field
                does not change the separate non-oETP receive-mode policy.";

            regwidth = 64;

            field {
                name = {INST_NAME, ".config.multicast_address.lo_word[31:0]"};
                desc = "Lower 32 bits [31:0] of the 48-bit multicast MAC address.";

                sw = rw;
                hw = r;
            } lo_word[31:0] = 0;

            field {
                name = {INST_NAME, ".config.multicast_address.hi_word[47:32]"};
                desc = "Upper 16 bits [47:32] of the 48-bit multicast MAC address.";

                sw = rw;
                hw = r;
            } hi_word[47:32] = 0;
        } multicast_address;

        reg non_oetp_control {
            name = {INST_NAME, ".config.non_oetp_control"};
            desc = "Receive policy for Ethernet frames that do not carry oETP traffic.";

            field {
                name = {INST_NAME, ".config.non_oetp_control.receive_mode[1:0]"};
                desc = "
                    Receive mode for non-oETP Ethernet frames:<ul>
                    <li>0: Drop all non-oETP Ethernet frames.</li>
                    <li>1: Filtered mode. Accept frames addressed to the configured local MAC
                    address and Ethernet broadcast frames.</li>
                    <li>2: Multicast mode. Accept the same frames as filtered mode, plus all
                    multicast-addressed frames.</li>
                    <li>3: Promiscuous mode. Accept all non-oETP Ethernet frames.</li>
                    </ul>
                    An accepted frame is directed to the non-oETP RX DMA channel when that channel
                    is armed; otherwise it is directed to the CSR AXI4-Stream sink.
                ";

                sw = rw;
                hw = r;
            } receive_mode[1:0] = 1;
        } non_oetp_control;

        reg rmem_timeout {
            name = {INST_NAME, ".config.rmem_timeout"};
            desc = "Timeout configuration for transparent RMEM operations.";

            field {
                name = {INST_NAME, ".config.rmem_timeout.cycles[31:0]"};
                desc = "Maximum wait for an RMEM response in endpoint clock cycles. Zero disables
                    the timeout and permits an indefinite response wait. Hardware samples this
                    value when it accepts an RMEM operation; subsequent writes apply to later
                    operations. The response timer starts after the complete request frame has
                    been accepted by the Ethernet-facing transmit stream and runs until the
                    complete matching response is received and validated through Ethernet TLAST.
                    RX backpressure counts toward the timeout; remaining local memory completion
                    does not. A valid response completing on the expiry edge takes priority,
                    including a valid ERROR_RSP with its reported cause. Hardware does not
                    retry; timeout handling and retry policy belong to software. Multicast
                    writes do not wait for a response and do not use this response timeout.
                    An RMEM read timeout terminates the access with all-ones read data and read
                    ACK; a write timeout terminates with write ACK. The external-RMEM boundary
                    uses no ERR signals. Failures set error and error_code in the associated
                    peers.entry[].dma register and may generate a separate RMEM_ERROR IRQ event.";

                sw = rw;
                hw = r;
            } cycles[31:0] = 0;
        } rmem_timeout;

        reg dma_timeout {
            name = {INST_NAME, ".config.dma_timeout"};
            desc = "Common response timeout for locally initiated unicast peer DMA fragments.";

            field {
                name = {INST_NAME, ".config.dma_timeout.cycles[31:0]"};
                desc = "Maximum wait for a response to one peer DMA fragment, in endpoint clock
                    cycles. This value is shared by all peers. Zero disables the timeout and
                    permits an indefinite response wait. Hardware samples this value when the
                    oETP engine accepts the fragment request; later writes apply to later
                    fragments. The response timer starts after the complete request frame has
                    been accepted by the Ethernet-facing transmit stream and runs until the
                    complete matching response is received and validated through Ethernet TLAST,
                    including EndOfData where present. RX backpressure counts toward the timeout;
                    remaining local memory completion does not. A valid response completing on
                    the expiry edge takes priority, including a valid ERROR_RSP with its reported
                    cause. On expiry, hardware
                    aborts the remaining fragments of that DMA transfer and reports error code
                    8 (timeout) in the peer DMA status. Hardware does not retry; software decides
                    whether to start another transfer. This timeout does not apply to multicast
                    writes, non-oETP DMA, or transparent RMEM operations.";

                sw = rw;
                hw = r;
            } cycles[31:0] = 0;
        } dma_timeout;

        reg dma_max_fragment_size {
            name = {INST_NAME, ".config.dma_max_fragment_size"};
            desc = "Common software-selected maximum memory fragment size for locally
                initiated peer DMA transfers. The synthesis-time frame limit remains fixed.";

            field {
                name = {INST_NAME, ".config.dma_max_fragment_size.bytes[31:0]"};
                desc = "Maximum meaningful memory bytes in one locally initiated DMA fragment,
                    excluding Ethernet/oETP headers, word padding, EndOfData and FCS. The
                    hardware rounds the written value down to a multiple of four before
                    validating it. The effective MFS must be at least four bytes and at most
                    4 * floor((MAX_RAW_FRAME_SIZE - 32) / 4). With an 8192-byte frame ceiling,
                    the effective range is 4 through 8160 bytes in steps of four, with reset
                    value 8160. For example, 31 selects 28, 7 selects 4, and 8161 through 8163
                    select 8160. Hardware snapshots the effective value when it accepts the
                    whole peer DMA transfer; later writes apply only to subsequent transfers.
                    The final fragment uses the exact remaining byte length and may be shorter
                    than four bytes. A written value of 0 through 3, or a rounded value above
                    the synthesized ceiling, rejects a new transfer with local error code 1
                    before issuing any memory or protocol operation. The CSR retains the
                    unrounded written value. This setting does not
                    restrict received peer requests, which use the synthesized fragment
                    ceiling, and does not affect RMEM, direct CSR streams or non-oETP DMA.";

                sw = rw;
                hw = r;
            } bytes[31:0] = (MAX_RAW_FRAME_SIZE > 32) ?
                ((MAX_RAW_FRAME_SIZE - 32) / 4) * 4 : 0;
        } dma_max_fragment_size;
    } config;

    regfile axis_if {
        name = {INST_NAME, ".axis_if"};
        desc = "Register file for the AXI4-Stream source and sink interfaces.";

        regfile source {
            name = {INST_NAME, ".axis_if.source"};
            desc = "Register file for the AXI4-Stream source interface.";

            reg data {
                name = {INST_NAME, ".axis_if.source.data"};
                desc = "Data register for the AXI4-Stream source interface.";

                field {
                    name = {INST_NAME, ".axis_if.source.data.tdata[31:0]"};
                    desc = "32-bit data value for the AXI4-Stream source interface.";

                    sw = rw;
                    hw = r;
                } tdata[31:0] = 0;
            } data;

            reg control {
                name = {INST_NAME, ".axis_if.source.control"};
                desc = "Control register for the AXI4-Stream source interface.";

                field {
                    name = {INST_NAME, ".axis_if.source.control.tvalid"};
                    desc = "Indicates that the AXI4-Stream source interface has valid data to send.
                        Once asserted by software, the field remains asserted until the transfer is
                        accepted by the destination.";

                    sw = rw;
                    hw = r;
                    hwclr = true;
                } tvalid[0:0] = 0;

                field {
                    name = {INST_NAME, ".axis_if.source.control.tlast"};
                    desc = "Indicates the last data word of a frame on the AXI4-Stream source
                        interface.";

                    sw = rw;
                    hw = r;
                } tlast[8:8] = 0;

                field {
                    name = {INST_NAME, ".axis_if.source.control.tkeep[3:0]"};
                    desc = "Indicates which byte lanes contain valid data on the AXI4-Stream source
                        interface.";

                    sw = rw;
                    hw = r;
                } tkeep[19:16] = 0;
            } control;

            reg status {
                name = {INST_NAME, ".axis_if.source.status"};
                desc = "Status register for the AXI4-Stream source interface.";

                field {
                    name = {INST_NAME, ".axis_if.source.status.tready"};
                    desc = "Indicates that the destination AXI4-Stream interface is ready to
                        receive data.";

                    sw = r;
                    hw = w;
                } tready[0:0] = 0;
            } status;
        } source;

        regfile sink {
            name = {INST_NAME, ".axis_if.sink"};
            desc = "Register file for the AXI4-Stream sink interface.";

            reg data {
                name = {INST_NAME, ".axis_if.sink.data"};
                desc = "Data register for the AXI4-Stream sink interface.";

                field {
                    name = {INST_NAME, ".axis_if.sink.data.tdata[31:0]"};
                    desc = "32-bit data value for the AXI4-Stream sink interface.";

                    sw = r;
                    hw = w;
                } tdata[31:0];
            } data;

            reg control {
                name = {INST_NAME, ".axis_if.sink.control"};
                desc = "Control register for the AXI4-Stream sink interface.";

                field {
                    name = {INST_NAME, ".axis_if.sink.control.tready"};
                    desc = "Indicates that the AXI4-Stream sink interface is ready to accept a
                        data transfer. Once asserted by software, the field remains asserted until
                        a transfer occurs.";

                    sw = rw;
                    hw = r;
                    hwclr = true;
                } tready[0:0] = 0;
            } control;

            reg status {
                name = {INST_NAME, ".axis_if.sink.status"};
                desc = "Status register for the AXI4-Stream sink interface.";

                field {
                    name = {INST_NAME, ".axis_if.sink.status.tvalid"};
                    desc = "Indicates that the AXI4-Stream sink interface has valid data
                        to receive.";

                    sw = r;
                    hw = w;
                } tvalid[0:0];

                field {
                    name = {INST_NAME, ".axis_if.sink.status.tlast"};
                    desc = "Indicates the last data word of a frame on the AXI4-Stream
                        sink interface.";

                    sw = r;
                    hw = w;
                } tlast[8:8];

                field {
                    name = {INST_NAME, ".axis_if.sink.status.tkeep[3:0]"};
                    desc = "Indicates which byte lanes contain valid data on the AXI4-Stream
                        sink interface.";

                    sw = r;
                    hw = w;
                } tkeep[19:16];
            } status;
        } sink;
    } axis_if;

    regfile non_oetp_dma {
        name = {INST_NAME, ".non_oetp_dma"};
        desc = "Endpoint-level DMA control and status for complete non-oETP Ethernet frames.
            Frame data includes the Ethernet header and payload, but excludes the preamble,
            Start Frame Delimiter (SFD), and Frame Check Sequence (FCS).";

        regfile tx {
            name = {INST_NAME, ".non_oetp_dma.tx"};
            desc = "Transmit DMA channel for complete non-oETP Ethernet frames.";

            reg buffer_address {
                name = {INST_NAME, ".non_oetp_dma.tx.buffer_address"};
                desc = "Local memory address of the non-oETP Ethernet frame to transmit.";

                field {
                    name = {INST_NAME, ".non_oetp_dma.tx.buffer_address.base[31:0]"};
                    desc = "32-bit byte address of the first byte of the transmit buffer.";

                    sw = rw;
                    hw = r;
                } base[31:0] = 0;
            } buffer_address;

            reg frame_length {
                name = {INST_NAME, ".non_oetp_dma.tx.frame_length"};
                desc = "Length of the complete non-oETP Ethernet frame to transmit.";

                field {
                    name = {INST_NAME, ".non_oetp_dma.tx.frame_length.bytes[31:0]"};
                    desc = "Frame length in bytes. Valid non-zero values shall not exceed
                        info.max_dma_frame_size_bytes.";

                    sw = rw;
                    hw = r;
                } bytes[31:0] = 0;
            } frame_length;

            reg command_status {
                name = {INST_NAME, ".non_oetp_dma.tx.command_status"};
                desc = "Command and completion status for the non-oETP transmit DMA channel.";

                field {
                    name = {INST_NAME, ".non_oetp_dma.tx.command_status.request"};
                    desc = "Writing one requests transmission of the configured frame. The field
                        remains asserted until the DMA engine accepts the request. Hardware clears
                        it upon acceptance; while the channel is busy, a newly asserted request
                        remains pending. Software or an RTL controller shall read the completion
                        status and transferred length of the previous request before asserting this
                        field for the next request.";

                    sw = rw;
                    hw = r;
                    hwclr = true;
                } request[8:8] = 0;

                field {
                    name = {INST_NAME, ".non_oetp_dma.tx.command_status.clear_errors"};
                    desc = "Writing one clears this channel's error flag and error code.
                        Hardware clears the command after accepting it. The command does not
                        abort an active transfer, clear done or transferred length, or complete
                        an IRQ claim. A new failure takes precedence over a simultaneous clear.
                        Starting or successfully completing a transfer preserves a recorded error.";

                    sw = rw;
                    hw = r;
                    hwclr = true;
                } clear_errors[9:9] = 0;

                field {
                    name = {INST_NAME, ".non_oetp_dma.tx.command_status.idle"};
                    desc = "Indicates that the channel has no accepted transfer in progress.
                        Hardware deasserts this field when a request is accepted and asserts it
                        when the transfer completes.";

                    sw = r;
                    hw = w;
                } idle[16:16];

                field {
                    name = {INST_NAME, ".non_oetp_dma.tx.command_status.done"};
                    desc = "Sticky successful-completion flag. Hardware sets this field after the
                        accepted transfer completes successfully and clears it when the next request
                        is accepted.";

                    sw = r;
                    hw = w;
                } done[24:24];

                field {
                    name = {INST_NAME, ".non_oetp_dma.tx.command_status.error"};
                    desc = "Sticky error-completion flag. Hardware sets this field when an
                        accepted transfer fails. Only command_status.clear_errors or endpoint
                        reset clears it; starting or successfully completing another transfer
                        preserves a recorded error.";

                    sw = r;
                    hw = w;
                } error[25:25];

                field {
                    name = {INST_NAME, ".non_oetp_dma.tx.command_status.error_code[31:28]"};
                    desc = "
                        Sticky error code for the most recent transmit failure:<ul>
                        <li>0: No error.</li>
                        <li>1: Invalid DMA configuration or descriptor.</li>
                        <li>2: AXI4-Stream length or TLAST error.</li>
                        <li>3: Frame exceeds the supported size or configured buffer capacity.</li>
                        <li>4: AXI read SLVERR response.</li>
                        <li>5: AXI read DECERR response.</li>
                        <li>6: AXI write SLVERR response.</li>
                        <li>7: AXI write DECERR response.</li>
                        <li>8-15: Reserved.</li>
                        </ul>
                        These errors describe local non-oETP DMA work. Only
                        command_status.clear_errors or endpoint reset clears this field.
                        A new failure replaces the code and takes precedence over a simultaneous
                        clear; successful transfers preserve the previous failure.
                    ";

                    sw = r;
                    hw = w;
                } error_code[31:28];
            } command_status;

            reg transferred_length {
                name = {INST_NAME, ".non_oetp_dma.tx.transferred_length"};
                desc = "Number of bytes transferred for the most recently accepted transmit
                    request.";

                field {
                    name = {INST_NAME, ".non_oetp_dma.tx.transferred_length.bytes[31:0]"};
                    desc = "Actual number of bytes transferred. Hardware clears this field when
                        the next request is accepted.";

                    sw = r;
                    hw = w;
                } bytes[31:0];
            } transferred_length;
        } tx;

        regfile rx {
            name = {INST_NAME, ".non_oetp_dma.rx"};
            desc = "Receive DMA channel for complete non-oETP Ethernet frames.";

            reg buffer_address {
                name = {INST_NAME, ".non_oetp_dma.rx.buffer_address"};
                desc = "Local memory address of the receive buffer for a non-oETP Ethernet frame.";

                field {
                    name = {INST_NAME, ".non_oetp_dma.rx.buffer_address.base[31:0]"};
                    desc = "32-bit byte address of the first byte of the receive buffer.";

                    sw = rw;
                    hw = r;
                } base[31:0] = 0;
            } buffer_address;

            reg buffer_capacity {
                name = {INST_NAME, ".non_oetp_dma.rx.buffer_capacity"};
                desc = "Capacity of the receive buffer for one complete non-oETP Ethernet frame.";

                field {
                    name = {INST_NAME, ".non_oetp_dma.rx.buffer_capacity.bytes[31:0]"};
                    desc = "Receive-buffer capacity in bytes. Valid non-zero values shall not exceed
                        info.max_dma_frame_size_bytes.";

                    sw = rw;
                    hw = r;
                } bytes[31:0] = 0;
            } buffer_capacity;

            reg command_status {
                name = {INST_NAME, ".non_oetp_dma.rx.command_status"};
                desc = "Command and completion status for the non-oETP receive DMA channel.";

                field {
                    name = {INST_NAME, ".non_oetp_dma.rx.command_status.request"};
                    desc = "Writing one arms reception into the configured buffer. The field remains
                        asserted until the DMA engine accepts the request. Hardware clears it upon
                        acceptance; while the channel is busy, a newly asserted request remains
                        pending. Software or an RTL controller shall read the completion status and
                        received length of the previous request before asserting this field for the
                        next request.";

                    sw = rw;
                    hw = r;
                    hwclr = true;
                } request[8:8] = 0;

                field {
                    name = {INST_NAME, ".non_oetp_dma.rx.command_status.clear_errors"};
                    desc = "Writing one clears this channel's error flag and error code.
                        Hardware clears the command after accepting it. The command does not
                        abort an active or armed receive, clear done or received length, or
                        complete an IRQ claim. A new failure takes precedence over a simultaneous
                        clear. Starting or successfully completing a transfer preserves a
                        recorded error.";

                    sw = rw;
                    hw = r;
                    hwclr = true;
                } clear_errors[9:9] = 0;

                field {
                    name = {INST_NAME, ".non_oetp_dma.rx.command_status.idle"};
                    desc = "Indicates that the channel has no accepted receive request in progress.
                        After acceptance, the channel may be armed and waiting for an eligible
                        non-oETP frame or may be writing a received frame to memory.";

                    sw = r;
                    hw = w;
                } idle[16:16];

                field {
                    name = {INST_NAME, ".non_oetp_dma.rx.command_status.armed"};
                    desc = "Indicates that the accepted receive request is waiting for an eligible
                        non-oETP Ethernet frame. Hardware sets this field when it accepts a request
                        and clears it when the first beat of the selected frame is accepted by the
                        RX DMA datapath. The frame-routing logic uses this field to select the
                        RX DMA path; otherwise an accepted non-oETP frame is directed to the
                        CSR AXI4-Stream sink.";

                    sw = r;
                    hw = w;
                } armed[17:17];

                field {
                    name = {INST_NAME, ".non_oetp_dma.rx.command_status.done"};
                    desc = "Sticky successful-completion flag. Hardware sets this field after a
                        received frame has been written successfully and clears it when the next
                        request is accepted.";

                    sw = r;
                    hw = w;
                } done[24:24];

                field {
                    name = {INST_NAME, ".non_oetp_dma.rx.command_status.error"};
                    desc = "Sticky error-completion flag. Hardware sets this field when an
                        accepted receive fails. Only command_status.clear_errors or endpoint
                        reset clears it; starting or successfully completing another receive
                        preserves a recorded error.";

                    sw = r;
                    hw = w;
                } error[25:25];

                field {
                    name = {INST_NAME, ".non_oetp_dma.rx.command_status.error_code[31:28]"};
                    desc = "
                        Sticky error code for the most recent receive failure:<ul>
                        <li>0: No error.</li>
                        <li>1: Invalid DMA configuration or descriptor.</li>
                        <li>2: AXI4-Stream length or TLAST error.</li>
                        <li>3: Received frame exceeds the configured buffer capacity.</li>
                        <li>4: AXI read SLVERR response.</li>
                        <li>5: AXI read DECERR response.</li>
                        <li>6: AXI write SLVERR response.</li>
                        <li>7: AXI write DECERR response.</li>
                        <li>8-15: Reserved.</li>
                        </ul>
                        Only command_status.clear_errors or endpoint reset clears this field.
                        A new failure replaces the code and takes precedence over a simultaneous
                        clear; successful transfers preserve the previous failure.
                    ";

                    sw = r;
                    hw = w;
                } error_code[31:28];
            } command_status;

            reg received_length {
                name = {INST_NAME, ".non_oetp_dma.rx.received_length"};
                desc = "Length of the most recently received non-oETP Ethernet frame.";

                field {
                    name = {INST_NAME, ".non_oetp_dma.rx.received_length.bytes[31:0]"};
                    desc = "Actual number of frame bytes written to the receive buffer. Hardware
                        clears this field when the next request is accepted.";

                    sw = r;
                    hw = w;
                } bytes[31:0];
            } received_length;
        } rx;
    } non_oetp_dma;

    regfile irq {
        name = {INST_NAME, ".irq"};
        desc = "Endpoint-level interrupt control and claim interface. Interrupt events from peer
            DMA, non-oETP DMA, direct AXI4-Stream transfers, and RMEM failures are serialized
            through a shared event FIFO.";

        reg control {
            name = {INST_NAME, ".irq.control"};
            desc = "Global interrupt-output control and interrupt-controller maintenance requests.";

            field {
                name = {INST_NAME, ".irq.control.global_enable"};
                desc = "Enables the physical endpoint IRQ output. Clearing this field masks the
                    output but does not prevent enabled events from being queued. Event capture is
                    controlled by irq.event_enable and, for peer DMA, by the selected peer's
                    dma.irq_enable field.";

                sw = rw;
                hw = r;
            } global_enable[0:0] = 0;

            field {
                name = {INST_NAME, ".irq.control.clear_errors"};
                desc = "Writing one requests clearing of the sticky irq.status.overflow and
                    irq.status.invalid_complete flags. The field remains asserted until hardware
                    accepts the request and clears it.";

                sw = rw;
                hw = r;
                hwclr = true;
            } clear_errors[8:8] = 0;
        } control;

        reg event_enable {
            name = {INST_NAME, ".irq.event_enable"};
            desc = "Enables generation of individual endpoint IRQ event classes. These fields
                control event capture; irq.control.global_enable only masks the physical
                IRQ output.";

            field {
                name = {INST_NAME, ".irq.event_enable.peer_dma_complete"};
                desc = "Enables PEER_DMA_COMPLETE events. A peer event is queued only when this
                    field and the selected peer's dma.irq_enable field were both set when the DMA
                    request was accepted. A failed incoming bulk DMA request also generates this
                    event for the peer resolved from the source MAC. For incoming failures,
                    hardware captures the per-peer enable when recording the failure and samples
                    this field at IRQ admission. Successful incoming requests generate no event.
                    CSR error recording and the error response do not wait for IRQ FIFO capacity.";

                sw = rw;
                hw = r;
            } peer_dma_complete[0:0] = 0;

            field {
                name = {INST_NAME, ".irq.event_enable.non_oetp_dma_tx_complete"};
                desc = "Enables NON_OETP_DMA_TX_COMPLETE events. Hardware samples this field when
                    it accepts a non-oETP transmit DMA request.";

                sw = rw;
                hw = r;
            } non_oetp_dma_tx_complete[1:1] = 0;

            field {
                name = {INST_NAME, ".irq.event_enable.non_oetp_dma_rx_complete"};
                desc = "Enables NON_OETP_DMA_RX_COMPLETE events. Hardware samples this field when
                    it accepts a non-oETP receive DMA request.";

                sw = rw;
                hw = r;
            } non_oetp_dma_rx_complete[2:2] = 0;

            field {
                name = {INST_NAME, ".irq.event_enable.non_oetp_direct_tx_complete"};
                desc = "Enables NON_OETP_DIRECT_TX_COMPLETE events. Hardware samples this field when
                    the first beat of a direct transmit frame is accepted from the CSR-facing
                    AXI4-Stream interface. When enabled, the frame start is accepted only after an
                    IRQ FIFO credit has been reserved. The event is generated when the final beat
                    is accepted by the oETP engine.";

                sw = rw;
                hw = r;
            } non_oetp_direct_tx_complete[3:3] = 0;

            field {
                name = {INST_NAME, ".irq.event_enable.non_oetp_direct_rx_available"};
                desc = "Enables NON_OETP_DIRECT_RX_AVAILABLE events. One event is generated when
                    the first beat of a new direct receive frame becomes valid on the CSR-facing
                    AXI4-Stream interface. When enabled, routing logic does not expose that first
                    TVALID until an IRQ FIFO credit is available, so the event cannot be lost.
                    The event does not depend on TLAST and therefore supports both cut-through and
                    frame-FIFO operation.";

                sw = rw;
                hw = r;
            } non_oetp_direct_rx_available[4:4] = 0;

            field {
                name = {INST_NAME, ".irq.event_enable.rmem_error"};
                desc = "Enables RMEM_ERROR events for locally initiated RMEM failures, including
                    timeout and an accepted ERROR_RSP, and failed incoming RMEM requests from a
                    resolved peer. Hardware records the associated peer's
                    dma.error and dma.error_code before
                    exposing the event and terminates the failed RMEM access without waiting
                    for IRQ FIFO capacity. For locally initiated failures the enable is sampled
                    when the failure is recorded; incoming failures sample it at IRQ admission.
                    The bulk DMA per-peer irq_enable does not gate RMEM_ERROR.
                    Successful RMEM accesses generate no event.";

                sw = rw;
                hw = r;
            } rmem_error[5:5] = 0;
        } event_enable;

        reg status {
            name = {INST_NAME, ".irq.status"};
            desc = "Status of the endpoint IRQ event FIFO and its reservation mechanism.";

            field {
                name = {INST_NAME, ".irq.status.claim_pending"};
                desc = "Indicates that at least one valid event is available in irq.claim.";

                sw = r;
                hw = w;
            } claim_pending[0:0];

            field {
                name = {INST_NAME, ".irq.status.credit_full"};
                desc = "Indicates that all event FIFO credits are occupied by queued claims or
                    reserved for admitted operations. While no credit is available, new
                    interrupt-enabled DMA requests are not accepted and the start of an
                    interrupt-enabled direct AXI4-Stream frame is backpressured.";

                sw = r;
                hw = w;
            } credit_full[1:1];

            field {
                name = {INST_NAME, ".irq.status.overflow"};
                desc = "Sticky internal-error flag indicating that an enabled event could not be
                    retained. Correct credit reservation, admission control, and AXI4-Stream
                    backpressure make this condition unreachable during normal operation. Clear with
                    irq.control.clear_errors.";

                sw = r;
                hw = w;
            } overflow[2:2];

            field {
                name = {INST_NAME, ".irq.status.invalid_complete"};
                desc = "Sticky protocol-error flag indicating that irq.complete.valid was accepted
                    while no claim was pending or that the completion token did not match the
                    current claim. No claim is removed on a mismatch. Clear with
                    irq.control.clear_errors.";

                sw = r;
                hw = w;
            } invalid_complete[3:3];

            field {
                name = {INST_NAME, ".irq.status.irq_asserted"};
                desc = "Reflects the current value of the physical endpoint IRQ output after
                    application of irq.control.global_enable.";

                sw = r;
                hw = w;
            } irq_asserted[4:4];

            field {
                name = {INST_NAME, ".irq.status.fifo_level[7:0]"};
                desc = "Number of valid claims currently queued in the IRQ event FIFO. Values
                    greater than 255 are reported as 255.";

                sw = r;
                hw = w;
            } fifo_level[15:8];

            field {
                name = {INST_NAME, ".irq.status.reserved_count[7:0]"};
                desc = "Number of event FIFO credits reserved for admitted DMA operations or direct
                    transmit frames whose events have not yet been queued. Values greater than 255
                    are reported as 255.";

                sw = r;
                hw = w;
            } reserved_count[23:16];
        } status;

        reg claim {
            name = {INST_NAME, ".irq.claim"};
            desc = "Read-only view of the event at the head of the IRQ event FIFO. Reading this
                register has no side effect, and all fields remain stable until a matching
                irq.complete request removes the claim.";

            field {
                name = {INST_NAME, ".irq.claim.peer_idx[10:0]"};
                desc = "Zero-based peer index for a PEER_DMA_COMPLETE or RMEM_ERROR event, in the range 0 through
                    NUM_OF_PEERS-1. The field is not applicable to other event sources and is driven
                    to zero for deterministic readback.";

                sw = r;
                hw = w;
            } peer_idx[10:0];

            field {
                name = {INST_NAME, ".irq.claim.source[3:0]"};
                desc = "
                    IRQ event source:<ul>
                    <li>0: PEER_DMA_COMPLETE. A peer DMA request completed with either success or
                    error; peer_idx identifies the peer.</li>
                    <li>1: NON_OETP_DMA_TX_COMPLETE. A non-oETP transmit DMA request completed with
                    either success or error.</li>
                    <li>2: NON_OETP_DMA_RX_COMPLETE. A non-oETP receive DMA request completed with
                    either success or error.</li>
                    <li>3: NON_OETP_DIRECT_TX_COMPLETE. The final beat of a direct non-oETP transmit
                    frame was accepted by the oETP engine.</li>
                    <li>4: NON_OETP_DIRECT_RX_AVAILABLE. The first beat of a new direct non-oETP
                    receive frame is available on the CSR-facing AXI4-Stream interface.</li>
                    <li>5: RMEM_ERROR. A locally initiated RMEM operation failed. The cause is
                    recorded in peers.entry[peer_idx].dma; peer_idx identifies the associated peer.</li>
                    <li>6-15: Reserved.</li>
                    </ul>
                    This field is meaningful only when valid is set.
                ";

                sw = r;
                hw = w;
            } source[14:11];

            field {
                name = {INST_NAME, ".irq.claim.sequence[15:0]"};
                desc = "Monotonically increasing event sequence number, modulo 65536. The sequence
                    number distinguishes otherwise identical claims and protects against stale or
                    repeated completion requests.";

                sw = r;
                hw = w;
            } sequence[30:15];

            field {
                name = {INST_NAME, ".irq.claim.valid"};
                desc = "Indicates that this register contains the valid event at the head of the
                    IRQ event FIFO. When clear, all other claim fields shall be ignored.";

                sw = r;
                hw = w;
            } valid[31:31];
        } claim;

        reg complete {
            name = {INST_NAME, ".irq.complete"};
            desc = "Completion request for the current IRQ claim. Software acknowledges an event by
                copying the complete 32-bit irq.claim value into this register.";

            field {
                name = {INST_NAME, ".irq.complete.peer_idx[10:0]"};
                desc = "Peer-index portion of the claim token.";

                sw = rw;
                hw = r;
            } peer_idx[10:0] = 0;

            field {
                name = {INST_NAME, ".irq.complete.source[3:0]"};
                desc = "Event-source portion of the claim token.";

                sw = rw;
                hw = r;
            } source[14:11] = 0;

            field {
                name = {INST_NAME, ".irq.complete.sequence[15:0]"};
                desc = "Sequence-number portion of the claim token.";

                sw = rw;
                hw = r;
            } sequence[30:15] = 0;

            field {
                name = {INST_NAME, ".irq.complete.valid"};
                desc = "Writing one submits the completion token. The field remains asserted until
                    hardware validates the token and clears it. A matching token removes the current
                    claim and releases its FIFO credit; an invalid token leaves the claim unchanged
                    and sets irq.status.invalid_complete.";

                sw = rw;
                hw = r;
                hwclr = true;
            } valid[31:31] = 0;
        } complete;
    } irq;

    regfile peers {
        name = {INST_NAME, ".peers"};
        desc = "Register file for remote peer configuration and memory region information.";

        regfile entry {
            name = {INST_NAME, ".peers.entry[0..NUM_OF_PEERS-1]"};
            desc = "Register file for a single remote peer configuration and memory region
                information.";

            reg mac_address {
                name = {INST_NAME, ".peers.entry[0..NUM_OF_PEERS-1].mac_address"};
                desc = "Remote peer 48-bit destination MAC address.";

                regwidth = 64;

                field {
                    name = {INST_NAME, ".peers.entry[0..NUM_OF_PEERS-1].mac_address.lo_word[31:0]"};
                    desc = "Lower 32 bits [31:0] of the 48-bit MAC address.";

                    sw = rw;
                    hw = r;
                } lo_word[31:0];

                field {
                    name = {INST_NAME, ".peers.entry[0..NUM_OF_PEERS-1].mac_address.hi_word[47:32]"};
                    desc = "Upper 16 bits [47:32] of the 48-bit MAC address.";

                    sw = rw;
                    hw = r;
                } hi_word[47:32];
            } mac_address;

            reg rmem_address {
                name = {INST_NAME, ".peers.entry[0..NUM_OF_PEERS-1].rmem_address"};
                desc = "Address offset of the virtual memory region corresponding to the remote
                    peer's memory.";

                field {
                    name = {INST_NAME, ".peers.entry[0..NUM_OF_PEERS-1].rmem_address.offset[31:0]"};
                    desc = "32-bit byte offset of the virtual memory region corresponding to the
                        remote peer's memory. The value shall be aligned to a 32-bit word boundary.";

                    sw = rw;
                    hw = r;
                } offset[31:0];
            } rmem_address;

            reg local_address {
                name = {INST_NAME, ".peers.entry[0..NUM_OF_PEERS-1].local_address"};
                desc = "Start address of the local memory region for DMA transfers.";

                field {
                    name = {INST_NAME, ".peers.entry[0..NUM_OF_PEERS-1].local_address.base[31:0]"};
                    desc = "Word-aligned 32-bit start address of the local memory region for
                        DMA transfers.";

                    sw = rw;
                    hw = r;
                } base[31:0];
            } local_address;

            reg remote_address {
                name = {INST_NAME, ".peers.entry[0..NUM_OF_PEERS-1].remote_address"};
                desc = "Start address of the remote peer's memory region.";

                field {
                    name = {INST_NAME, ".peers.entry[0..NUM_OF_PEERS-1].remote_address.base[31:0]"};
                    desc = "Word-aligned 32-bit start address of the remote peer's memory region.";

                    sw = rw;
                    hw = r;
                } base[31:0];
            } remote_address;

            reg size {
                name = {INST_NAME, ".peers.entry[0..NUM_OF_PEERS-1].size"};
                desc = "Size of the remote peer's memory region.";

                field {
                    name = {INST_NAME, ".peers.entry[0..NUM_OF_PEERS-1].size.bytes[31:0]"};
                    desc = "32-bit size of the remote peer's memory region in bytes.";

                    sw = rw;
                    hw = r;
                } bytes[31:0];
            } size;

            reg dma {
                name = {INST_NAME, ".peers.entry[0..NUM_OF_PEERS-1].dma"};
                desc = "DMA/RMEM configuration and control for the remote peer, with shared
                    sticky error reporting. RMEM and bulk DMA retain separate IRQ event classes.";

                field {
                    name = {INST_NAME, ".peers.entry[0..NUM_OF_PEERS-1].dma.mode[1:0]"};
                    desc = "
                        DMA mode and responder access policy for the remote peer:<ul>

                        <li>0: Disabled. Locally initiated DMA and transparent RMEM
                        operations are disabled, and incoming oETP memory requests from
                        this peer are rejected.</li>

                        <li>1: Transparent RMEM mode. Accesses to the virtual RMEM region
                        are translated into individual remote memory accesses. Incoming
                        transparent RMEM read and write requests from this peer are
                        permitted. Bulk DMA read and write requests are rejected.</li>

                        <li>2: Mirror-to-local mode. A locally initiated DMA request fetches
                        the remote memory region into the configured local memory region
                        using remote DMA reads. On the responder side, incoming bulk DMA
                        write requests from this peer are permitted and target the
                        configured local memory region. Incoming bulk DMA read requests
                        are rejected.</li>

                        <li>3: Mirror-to-remote mode. A locally initiated DMA request sends
                        the configured local memory region to the remote memory region
                        using remote DMA writes. On the responder side, incoming bulk DMA
                        read requests from this peer are permitted and source data from
                        the configured local memory region. Incoming bulk DMA write
                        requests are rejected.</li>

                        </ul>

                        Consequently, a mirror relationship uses complementary modes:
                        an initiator operating in mirror-to-local mode communicates with
                        a responder entry configured as mirror-to-remote, while an
                        initiator operating in mirror-to-remote mode communicates with a
                        responder entry configured as mirror-to-local.
                    ";

                    sw = rw;
                    hw = r;
                } mode[1:0];

                field {
                    name = {INST_NAME, ".peers.entry[0..NUM_OF_PEERS-1].dma.irq_enable"};
                    desc = "Enables generation of a PEER_DMA_COMPLETE IRQ event for this peer.
                        Hardware samples this field together with irq.event_enable.peer_dma_complete
                        when it accepts the peer DMA request. Changing the field while a transfer is
                        active does not affect that transfer. Disabling the field does not affect
                        DMA execution or the done, error, and error_code status fields. For a
                        failed incoming bulk DMA request, this field is captured when recording
                        the failure and irq.event_enable.peer_dma_complete is sampled at IRQ
                        admission. The event identifies this peer by the received source MAC.
                        Successful incoming requests generate no event. RMEM errors use their
                        separate irq.event_enable.rmem_error path.";

                    sw = rw;
                    hw = r;
                } irq_enable[2:2] = 0;

                field {
                    name = {INST_NAME, ".peers.entry[0..NUM_OF_PEERS-1].dma.request[8:8]"};
                    desc = "Writing one requests a DMA transfer to or from the remote peer,
                        according to dma.mode. The field remains asserted until the DMA engine
                        accepts and snapshots the request. Hardware clears it upon acceptance;
                        while a transfer for this peer is active, a newly asserted request remains
                        pending. Software or an RTL controller shall read the completion status of
                        the previous request before asserting this field for the next request and
                        shall keep the peer configuration stable while this field is asserted.";

                    sw = rw;
                    hw = r;
                    hwclr = true;
                } request[8:8] = 0;

                field {
                    name = {INST_NAME, ".peers.entry[0..NUM_OF_PEERS-1].dma.clear_error"};
                    desc = "Writing one clears this peer's shared RMEM/DMA error flag and error
                        code. The field remains asserted until hardware accepts and clears the
                        command. It does not abort an active operation, clear done, or complete
                        an IRQ claim. A new failure takes precedence over a simultaneous clear.
                        Starting or successfully completing an operation does not clear a
                        previously recorded error.";

                    sw = rw;
                    hw = r;
                    hwclr = true;
                } clear_error[9:9] = 0;

                field {
                    name = {INST_NAME, ".peers.entry[0..NUM_OF_PEERS-1].dma.idle[16:16]"};
                    desc = "Indicates whether this peer has no accepted DMA request in progress.
                        Hardware deasserts this field when a request is accepted and asserts it
                        after all fragments of the requested block have completed.";

                    sw = r;
                    hw = w;
                } idle[16:16];

                field {
                    name = {INST_NAME, ".peers.entry[0..NUM_OF_PEERS-1].dma.done[24:24]"};
                    desc = "Sticky successful-completion flag for this peer. Hardware sets this
                        field after all fragments of the accepted block transfer complete
                        successfully and clears it when the next request is accepted.";

                    sw = r;
                    hw = w;
                } done[24:24];

                field {
                    name = {INST_NAME, ".peers.entry[0..NUM_OF_PEERS-1].dma.error[25:25]"};
                    desc = "Shared sticky RMEM/DMA error flag for this peer. Hardware sets this
                        field when a locally initiated RMEM access or bulk DMA transfer fails,
                        or when servicing an incoming RMEM or bulk DMA request from this peer
                        fails. Received requests are associated by source MAC. An incoming failure
                        records its code before exposing its error response, independently of
                        IRQ enable; it does not change the locally initiated dma.request, idle,
                        or done state. An incomplete incoming DMA data frame records remote
                        stream code 10. Multicast response suppression does not suppress this
                        local error record or an enabled event.
                        Only dma.clear_error or endpoint reset clears a latched error; starting
                        or successfully completing another operation does not clear it. The
                        flag is independent of the IRQ event-enable fields.";

                    sw = r;
                    hw = w;
                } error[25:25];

                field {
                    name = {INST_NAME, ".peers.entry[0..NUM_OF_PEERS-1].dma.error_code[31:28]"};
                    desc = "
                        Shared sticky code for the most recent RMEM or bulk DMA failure for this peer:<ul>
                        <li>0: No error.</li>
                        <li>1: Local invalid request, configuration, descriptor, or parameters.</li>
                        <li>2: Local stream/PDU length or TLAST error.</li>
                        <li>3: Local supported-size or buffer-capacity overflow.</li>
                        <li>4: Local AXI read SLVERR response.</li>
                        <li>5: Local AXI read DECERR response.</li>
                        <li>6: Local AXI write SLVERR response.</li>
                        <li>7: Local AXI write DECERR response.</li>
                        <li>8: Local peer response timeout or Request ID wrap collision. An RMEM access
                            terminates through its ACK-only boundary; a bulk DMA timeout aborts
                            the remaining fragments. Hardware does not retry.</li>
                        <li>9: Remote invalid request, configuration, descriptor, or parameters.</li>
                        <li>10: Remote stream/PDU length or TLAST error. Also used directly by
                            the receiver of an incomplete DMA_WRITE_REQ or DMA_READ_RSP,
                            including missing or incorrect EndOfData.</li>
                        <li>11: Remote supported-size or buffer-capacity overflow.</li>
                        <li>12: Remote AXI read SLVERR response.</li>
                        <li>13: Remote AXI read DECERR response.</li>
                        <li>14: Remote AXI write SLVERR response.</li>
                        <li>15: Remote AXI write DECERR response.</li>
                        </ul>
                        Codes 1-8 describe errors detected by this endpoint, including
                        malformed responses, local memory failures, and failures while servicing
                        received requests. Codes 9-15 describe
                        failures reported by the responding peer through a valid ERROR_RSP.
                        Code 10 additionally reports an incomplete incoming DMA data frame
                        detected at this endpoint, without requiring an ERROR_RSP first.
                        A missing or incorrect EndOfData uses this same code even when
                        Ethernet padding masks the short data length. A receiver of an
                        incomplete unicast DMA_WRITE_REQ records CSR code 10 but sends
                        ERROR_RSP wire cause 2; multicast writes generate no response.
                        ERROR_RSP carries a 32-bit cause in the range 1-7, which the initiating
                        oETP engine validates and maps to CSR code = 8 + wire code. Values
                        outside 1-7 are invalid response parameters and record local code 1;
                        they must not be truncated or mistaken for local TIMEOUT = 8.
                        The oETP initiator completion channel carries this final CSR encoding
                        for both RMEM and bulk DMA. The responder completion channel reports
                        its cause 1-7 for serialization as ERROR_RSP; cause 2 on an incomplete
                        received bulk write corresponds to receiver CSR code 10. Hardware
                        clears this field only on dma.clear_error or endpoint reset. Successful
                        operations preserve a recorded failure. A new failure replaces the code
                        and takes precedence over a simultaneous clear. A failed streaming
                        transfer may have partially modified memory; error reporting does not
                        provide rollback or an exact count of modified bytes. Software manages
                        buffer synchronization and recovery.
                    ";

                    sw = r;
                    hw = w;
                } error_code[31:28];
            } dma;
        } entry[NUM_OF_PEERS];
    } peers;

    external regfile rmem {
        name = {INST_NAME, ".rmem"};
        desc = "Virtual memory region for all remote peers, with offsets and sizes defined in the
            peers regfile.";

        reg word {
            name = {INST_NAME, ".rmem.word[0..RMEM_TOTAL_DEPTH-1]"};
            desc = "32-bit word in the virtual memory region.";

            field {
                name = {INST_NAME, ".rmem.word[0..RMEM_TOTAL_DEPTH-1].data[31:0]"};
                desc = "Data stored in this virtual memory word.";

                sw = rw;
                hw = rw;
            } data[31:0];
        } word[RMEM_TOTAL_DEPTH];
    } rmem;
};

addrmap openenoc_endpoint_interface_top {
    name = "openenoc_endpoint_interface_top";
    desc = "Control and status address map for an openENOC Endpoint Interface instance.";

    littleendian;
    default accesswidth = 32;
    default regwidth = 32;
    default alignment = 4;
    addressing = regalign;

    openenoc_endpoint_interface #(
        .RMEM_TOTAL_DEPTH(1),
        .NUM_OF_PEERS(1),
        .MAX_RAW_FRAME_SIZE(8192),
        .HAS_PEER_DMA(1),
        .HAS_NON_OETP_DMA(1),
        .HAS_DIRECT_AXIS(1),
        .HAS_RMEM(1),
        .HAS_IRQ(1),
        .INST_NAME("openenoc_endpoint_interface")
    ) openenoc_endpoint_interface;
};
