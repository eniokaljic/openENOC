// SPDX-FileCopyrightText: 2026 Enio Kaljic
// SPDX-License-Identifier: CERN-OHL-S-2.0

regfile openenoc_endpoint_interface #(
    longint unsigned RMEM_TOTAL_DEPTH = 256,
    longint unsigned NUM_OF_PEERS = 1,
    string INST_NAME = "openenoc_endpoint_interface"
) {
    name = INST_NAME;
    desc = "Control and status register file for an openENOC Endpoint Interface instance.";

    default accesswidth = 32;
    default regwidth = 32;
    default alignment = 4;

    reg info {
        name = {INST_NAME, ".info"};
        desc = "Read-only information register for this openENOC Endpoint Interface instance.";

        regwidth = 64;

        field {
            name = {INST_NAME, ".info.rmem_total_depth[15:0]"};
            desc = "Total depth of the shared memory region for all remote peers. This field reflects the RMEM_TOTAL_DEPTH parameter value.";

            sw = r;
            hw = r;
        } rmem_total_depth[31:0] = RMEM_TOTAL_DEPTH;

        field {
            name = {INST_NAME, ".info.num_of_peers[31:16]"};
            desc = "Number of remote peers supported by this openENOC Endpoint Interface instance. This field reflects the NUM_OF_PEERS parameter value.";

            sw = r;
            hw = r;
        } num_of_peers[63:32] = NUM_OF_PEERS;
    } info;

    regfile config {
        name = {INST_NAME, ".config"};
        desc = "Configuration register file for this openENOC Endpoint Interface instance.";

        reg mac_address {
            name = {INST_NAME, ".config.mac_address"};
            desc = "Local site 48-bit destination MAC address.";

            regwidth = 64;

            field {
                name = {INST_NAME, ".config.mac_address.lo_word[31:0]"};
                desc = "Lower 32 bits [31:0] of the 48-bit MAC address.";

                sw = rw;
                hw = rw;
            } lo_word[31:0] = 0;

            field {
                name = {INST_NAME, ".config.mac_address.hi_word[47:32]"};
                desc = "Upper 16 bits [47:32] of the 48-bit MAC address.";

                sw = rw;
                hw = rw;
            } hi_word[47:32] = 0;
        } mac_address;
    } config;

    regfile axis_if {
        name = {INST_NAME, ".axis_if"};
        desc = "Register file for the AXI4-Stream source and sink interfaces.";

        regfile source {
            name = {INST_NAME, ".axis_if.source"};
            desc = "Register file for the AXI4-Stream source interface.";

            reg data {
                name = {INST_NAME, ".axis_if.source.data"};
                desc = "Data register for the AXI4-Stream source interface.";

                field {
                    name = {INST_NAME, ".axis_if.source.data.tdata[31:0]"};
                    desc = "32-bit data value for the AXI4-Stream source interface.";

                    sw = rw;
                    hw = r;
                } tdata[31:0] = 0;
            } data;

            reg control {
                name = {INST_NAME, ".axis_if.source.control"};
                desc = "Control register for the AXI4-Stream source interface.";

                field {
                    name = {INST_NAME, ".axis_if.source.control.tvalid"};
                    desc = "Indicates that the AXI4-Stream source interface has valid data to send. Once asserted by software, the field remains asserted until the transfer is accepted by the destination.";

                    sw = rw;
                    hw = r;
                    hwclr = true;
                } tvalid[0:0] = 0;

                field {
                    name = {INST_NAME, ".axis_if.source.control.tlast"};
                    desc = "Indicates the last data word of a frame on the AXI4-Stream source interface.";

                    sw = rw;
                    hw = r;
                } tlast[8:8] = 0;

                field {
                    name = {INST_NAME, ".axis_if.source.control.tkeep[3:0]"};
                    desc = "Indicates which byte lanes contain valid data on the AXI4-Stream source interface.";

                    sw = rw;
                    hw = r;
                } tkeep[19:16] = 0;
            } control;

            reg status {
                name = {INST_NAME, ".axis_if.source.status"};
                desc = "Status register for the AXI4-Stream source interface.";

                field {
                    name = {INST_NAME, ".axis_if.source.status.tready"};
                    desc = "Indicates that the destination AXI4-Stream interface is ready to receive data.";

                    sw = r;
                    hw = w;
                } tready[0:0] = 0;
            } status;
        } source;

        regfile sink {
            name = {INST_NAME, ".axis_if.sink"};
            desc = "Register file for the AXI4-Stream sink interface.";

            reg data {
                name = {INST_NAME, ".axis_if.sink.data"};
                desc = "Data register for the AXI4-Stream sink interface.";

                field {
                    name = {INST_NAME, ".axis_if.sink.data.tdata[31:0]"};
                    desc = "32-bit data value for the AXI4-Stream sink interface.";

                    sw = r;
                    hw = w;
                } tdata[31:0];
            } data;

            reg control {
                name = {INST_NAME, ".axis_if.sink.control"};
                desc = "Control register for the AXI4-Stream sink interface.";

                field {
                    name = {INST_NAME, ".axis_if.sink.control.tready"};
                    desc = "Indicates that the AXI4-Stream sink interface is ready to accept a data transfer. Once asserted by software, the field remains asserted until a transfer occurs.";

                    sw = rw;
                    hw = r;
                    hwclr = true;
                } tready[0:0] = 0;
            } control;

            reg status {
                name = {INST_NAME, ".axis_if.sink.status"};
                desc = "Status register for the AXI4-Stream sink interface.";

                field {
                    name = {INST_NAME, ".axis_if.sink.status.tvalid"};
                    desc = "Indicates that the AXI4-Stream sink interface has valid data to receive.";

                    sw = r;
                    hw = w;
                } tvalid[0:0];

                field {
                    name = {INST_NAME, ".axis_if.sink.status.tlast"};
                    desc = "Indicates the last data word of a frame on the AXI4-Stream sink interface.";

                    sw = r;
                    hw = w;
                } tlast[8:8];

                field {
                    name = {INST_NAME, ".axis_if.sink.status.tkeep[3:0]"};
                    desc = "Indicates which byte lanes contain valid data on the AXI4-Stream sink interface.";

                    sw = r;
                    hw = w;
                } tkeep[19:16];
            } status;
        } sink;
    } axis_if;

    regfile peers {
        name = {INST_NAME, ".peers"};
        desc = "Register file for remote peer configuration and memory region information.";

        regfile entry {
            name = {INST_NAME, ".peers.entry[0..NUM_OF_PEERS-1]"};
            desc = "Register file for a single remote peer configuration and memory region information.";

            reg mac_address {
                name = {INST_NAME, ".peers.entry[0..NUM_OF_PEERS-1].mac_address"};
                desc = "Remote peer 48-bit destination MAC address.";

                regwidth = 64;

                field {
                    name = {INST_NAME, ".peers.entry[0..NUM_OF_PEERS-1].mac_address.lo_word[31:0]"};
                    desc = "Lower 32 bits [31:0] of the 48-bit MAC address.";

                    sw = rw;
                    hw = rw;
                } lo_word[31:0];

                field {
                    name = {INST_NAME, ".peers.entry[0..NUM_OF_PEERS-1].mac_address.hi_word[47:32]"};
                    desc = "Upper 16 bits [47:32] of the 48-bit MAC address.";

                    sw = rw;
                    hw = rw;
                } hi_word[47:32];
            } mac_address;

            reg rmem_address {
                name = {INST_NAME, ".peers.entry[0..NUM_OF_PEERS-1].rmem_address"};
                desc = "Address offset of the virtual memory region corresponding to the remote peer's memory.";

                field {
                    name = {INST_NAME, ".peers.entry[0..NUM_OF_PEERS-1].rmem_address.offset[31:0]"};
                    desc = "Word-aligned 32-bit address offset of the virtual memory region corresponding to the remote peer's memory.";

                    sw = rw;
                    hw = r;
                } offset[31:0];
            } rmem_address;

            reg local_address {
                name = {INST_NAME, ".peers.entry[0..NUM_OF_PEERS-1].local_address"};
                desc = "Start address of the local memory region for DMA transfers.";

                field {
                    name = {INST_NAME, ".peers.entry[0..NUM_OF_PEERS-1].local_address.base[31:0]"};
                    desc = "Word-aligned 32-bit start address of the local memory region for DMA transfers.";

                    sw = rw;
                    hw = r;
                } base[31:0];
            } local_address;

            reg remote_address {
                name = {INST_NAME, ".peers.entry[0..NUM_OF_PEERS-1].remote_address"};
                desc = "Start address of the remote peer's memory region.";

                field {
                    name = {INST_NAME, ".peers.entry[0..NUM_OF_PEERS-1].remote_address.base[31:0]"};
                    desc = "Word-aligned 32-bit start address of the remote peer's memory region.";

                    sw = rw;
                    hw = r;
                } base[31:0];
            } remote_address;

            reg size {
                name = {INST_NAME, ".peers.entry[0..NUM_OF_PEERS-1].size"};
                desc = "Size of the remote peer's memory region.";

                field {
                    name = {INST_NAME, ".peers.entry[0..NUM_OF_PEERS-1].size.bytes[31:0]"};
                    desc = "32-bit size of the remote peer's memory region in bytes.";

                    sw = rw;
                    hw = r;
                } bytes[31:0];
            } size;

            reg dma {
                name = {INST_NAME, ".peers.entry[0..NUM_OF_PEERS-1].dma"};
                desc = "DMA configuration and control for the remote peer.";

                field {
                    name = {INST_NAME, ".peers.entry[0..NUM_OF_PEERS-1].dma.mode[1:0]"};
                    desc = "
                        DMA mode for transfers to/from the remote peer:<ul>
                        <li>0: DMA transfers to/from the remote peer are disabled.</li>
                        <li>1: DMA transfers to/from the remote peer are enabled in transparent mode, where accesses to the virtual memory region are directly translated to corresponding accesses to the remote peer's memory region (transactions are word-by-word, i.e., per virtual memory access).</li>
                        <li>2: DMA transfers to/from the remote peer are enabled in mirror-to-local mode, where the local memory region is used instead of the virtual memory region. The state of the remote peer's memory region (remote_address, size) is fetched from the remote peer on demand or periodically.</li>
                        <li>3: DMA transfers to/from the remote peer are enabled in mirror-to-remote mode, where the remote memory region is used instead of the virtual memory region. The state of the local peer's memory region (local_address, size) is sent to the remote peer on demand or periodically.</li>
                        </ul>
                    ";

                    sw = rw;
                    hw = r;
                } mode[1:0];

                field {
                    name = {INST_NAME, ".peers.entry[0..NUM_OF_PEERS-1].dma.request[8:8]"};
                    desc = "Writing a 1 to this field initiates a DMA transfer to/from the remote peer. This field is a single-pulse register that is automatically cleared back to zero after being written.";

                    singlepulse = true;
                    sw = rw;
                    hw = r;
                } request[8:8] = 0;

                field {
                    name = {INST_NAME, ".peers.entry[0..NUM_OF_PEERS-1].dma.idle[16:16]"};
                    desc = "Indicates whether the DMA transfer to/from the remote peer is idle. A value of 1 indicates that the DMA transfer is idle, while a value of 0 indicates that the DMA transfer is in progress.";

                    sw = r;
                    hw = w;
                } idle[16:16];

                field {
                    name = {INST_NAME, ".peers.entry[0..NUM_OF_PEERS-1].dma.done[24:24]"};
                    desc = "Indicates whether the DMA transfer to/from the remote peer has been successful. A value of 1 indicates that the DMA transfer has completed successfully, while a value of 0 indicates that the DMA transfer is still in progress or has encountered an error.";

                    sw = r;
                    hw = w;
                } done[24:24];

                field {
                    name = {INST_NAME, ".peers.entry[0..NUM_OF_PEERS-1].dma.error[25:25]"};
                    desc = "Indicates whether the DMA transfer to/from the remote peer has encountered an error. A value of 1 indicates an error, while a value of 0 indicates no error.";

                    sw = r;
                    hw = w;
                } error[25:25];
            } dma;
        } entry[NUM_OF_PEERS];
    } peers;

    external regfile rmem {
        name = {INST_NAME, ".rmem"};
        desc = "Virtual memory region for all remote peers, with offsets and sizes defined in the peers regfile.";

        reg word {
            name = {INST_NAME, ".rmem.word[0..RMEM_TOTAL_DEPTH-1]"};
            desc = "32-bit word in the virtual memory region.";

            field {
                name = {INST_NAME, ".rmem.word[0..RMEM_TOTAL_DEPTH-1].data[31:0]"};
                desc = "Data stored in this virtual memory word.";

                sw = rw;
                hw = rw;
            } data[31:0];
        } word[RMEM_TOTAL_DEPTH];
    } rmem;
};

addrmap openenoc_endpoint_interface_top {
    name = "openenoc_endpoint_interface_top";
    desc = "Control and status address map for an openENOC Endpoint Interface instance.";

    littleendian;
    default accesswidth = 32;
    default regwidth = 32;
    default alignment = 4;
    addressing = regalign;

    openenoc_endpoint_interface #(
        .RMEM_TOTAL_DEPTH(1),
        .NUM_OF_PEERS(1),
        .INST_NAME("openenoc_endpoint_interface")
    ) openenoc_endpoint_interface;
};
